//*******************************************************************************
// Long-Channel CMOS Process in Cadence Spectre Syntax
//
// Extracted from:
// R. Jacob Baker; CMOS Circuit Design, Layout and Simulation; Third Edition
// IEEE Press Series on Microelectronic Systems; ISBN 978-0-470-88132-3
//
// Changes:
// o remove 'kp' from models because Spectre 20.1 says that 'kp' and 'uo'
//   are inconsistent
// o wrap model in subcircuit
// o add statistics block for dcmatch
//******************************************************************************
parameters
+ Avt_nmos = 0
+ Au0_nmos = 0
+ Avt_pmos = 0
+ Au0_pmos = 0

statistics{
  process{
  }
  mismatch{
    vary Avt_nmos                  dist=gauss std=0.009
    vary Au0_nmos                  dist=gauss std=0.006
    vary Avt_pmos                  dist=gauss std=0.012
    vary Au0_pmos                  dist=gauss std=0.009
  }
}
subckt nmos (D G S B)
parameters w=10 l=1

m1 (D G S B) nchmod w=w l=l ad=w*2 as=w*2 pd=w+4 ps=w+4

model nchmod mos3 type = n
+tox = 200e-10          nsub = 1e17          gamma = 0.5
+phi = 0.7              delta = 3.0
+vto = 0.8 + Avt_nmos/sqrt(w*l)
+uo=650 + Au0_nmos/sqrt(w*l)
+eta = 3e-6             theta = 0.1
+vmax = 1e5             kappa = 0.3
+rsh = 0                nfs = 1e12           tpg = 1
+xj = 500e-9            ld = 100e-9
+cgdo = 200e-12         cgso = 200e-12       cgbo = 1e-10
+cj = 400e-6            pb = 1               mj = 0.5
+cjsw = 300e-12         mjsw = 0.5

ends nmos

subckt pmos (D G S B)
parameters w=10 l=1

m1 (D G S B) pchmod w=w l=l ad=w*2 as=w*2 pd=w+4 ps=w+4

model pchmod mos3 type = p
+tox = 200e-10          nsub = 1e17          gamma = 0.6
+phi = 0.7              delta = 0.1
+vto = -0.9 + Avt_pmos/sqrt(w*l)
+uo = 250 + Au0_pmos/sqrt(w*l)
+eta = 0                theta = 0.1
+vmax = 5e4             kappa = 1
+rsh = 0                nfs = 1e12           tpg = -1
+xj = 500e-9            ld = 100e-9
+cgdo = 200e-12         cgso = 200e-12       cgbo = 1e-10
+cj = 400e-6            pb = 1               mj = 0.5
+cjsw = 300e-12         mjsw = 0.5
ends pmos
